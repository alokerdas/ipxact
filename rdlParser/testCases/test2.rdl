/*signal gen_reset_signal_type {
 name = "Generic Reset Signal";
 desc = "This is a generic reset signal used to reset";
};
gen_reset_signal_type generic_reset;
*/
//
// This example shows the concept of a register file
// A register file is a group of registers that belong together...
// Now we can easily instance multiple fifo status registers very easily...
//
regfile fifoRfile {
  reg pointerReg { field { we; hwmask; } data[31:0]; };
  reg fifoStatusReg {
    field {} full;
    field {} empty;
    field {} almost_empty[4:4];
    field {} almost_full[5:5];
    full->reset = 1'b0;
    full->resetsignal = generic_reset;
    // Just the full signal uses generic reset. Others use reset...
    empty->reset = 1'b1;
    almost_empty->reset = 1'b1;
    almost_full ->reset = 1'b0;
  };
  pointerReg head; // Define a register pointing to the head of the fifo
  head->resetsignal = generic_reset;
  // Assign an alternate reset to register head
  pointerReg tail; // Define a register pointing to the tail of a fifo
  fifoStatusReg status; // Define a register for the Fifo's Status
};
